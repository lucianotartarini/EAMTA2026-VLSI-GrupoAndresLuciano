* Extracted by KLayout with SG13G2 LVS runset on : 30/03/2026 23:44

.SUBCKT xorgate
M$1 \$1 \$6 \$3 \$1 sg13_lv_nmos L=0.15u W=1.5u AS=0.51p AD=0.285p PS=3.68u
+ PD=1.88u
M$2 \$3 \$7 \$4 \$1 sg13_lv_nmos L=0.15u W=1.5u AS=0.285p AD=0.51p PS=1.88u
+ PD=3.68u
M$3 \$1 \$2 \$5 \$1 sg13_lv_nmos L=0.15u W=1.5u AS=0.51p AD=0.285p PS=3.68u
+ PD=1.88u
M$4 \$5 \$14 \$4 \$1 sg13_lv_nmos L=0.15u W=1.5u AS=0.285p AD=0.51p PS=1.88u
+ PD=3.68u
M$5 \$1 \$2 \$6 \$1 sg13_lv_nmos L=0.15u W=0.75u AS=0.255p AD=0.255p PS=2.18u
+ PD=2.18u
M$6 \$1 \$14 \$7 \$1 sg13_lv_nmos L=0.15u W=0.75u AS=0.255p AD=0.255p PS=2.18u
+ PD=2.18u
M$7 \$15 \$2 \$6 \$15 sg13_lv_pmos L=0.15u W=1.5u AS=0.51p AD=0.51p PS=3.68u
+ PD=3.68u
M$8 \$15 \$14 \$7 \$15 sg13_lv_pmos L=0.15u W=1.5u AS=0.51p AD=0.51p PS=3.68u
+ PD=3.68u
M$9 \$15 \$6 \$16 \$15 sg13_lv_pmos L=0.15u W=1.5u AS=0.51p AD=0.285p PS=3.68u
+ PD=1.88u
M$10 \$16 \$7 \$15 \$15 sg13_lv_pmos L=0.15u W=1.5u AS=0.285p AD=0.51p PS=1.88u
+ PD=3.68u
M$11 \$16 \$2 \$4 \$15 sg13_lv_pmos L=0.15u W=1.5u AS=0.51p AD=0.285p PS=3.68u
+ PD=1.88u
M$12 \$4 \$14 \$16 \$15 sg13_lv_pmos L=0.15u W=1.5u AS=0.285p AD=0.51p PS=1.88u
+ PD=3.68u
.ENDS xorgate
