* Extracted by KLayout with SG13G2 LVS runset on : 07/04/2026 01:20

.SUBCKT count4bits
M$1 \$1 \$11 \$4 \$1 sg13_lv_nmos L=0.15u W=1.5u AS=0.51p AD=0.285p PS=3.68u
+ PD=1.88u
M$2 \$4 \$12 \$5 \$1 sg13_lv_nmos L=0.15u W=1.5u AS=0.285p AD=0.51p PS=1.88u
+ PD=3.68u
M$3 \$1 \$2 \$6 \$1 sg13_lv_nmos L=0.15u W=1.5u AS=0.51p AD=0.285p PS=3.68u
+ PD=1.88u
M$4 \$6 \$7 \$5 \$1 sg13_lv_nmos L=0.15u W=1.5u AS=0.285p AD=0.51p PS=1.88u
+ PD=3.68u
M$5 \$1 \$2 \$8 \$1 sg13_lv_nmos L=0.15u W=1.5u AS=0.51p AD=0.285p PS=3.68u
+ PD=1.88u
M$6 \$8 \$7 \$9 \$1 sg13_lv_nmos L=0.15u W=1.5u AS=0.285p AD=0.51p PS=1.88u
+ PD=3.68u
M$7 \$5 \$3 \$14 \$1 sg13_lv_nmos L=0.15u W=0.75u AS=0.255p AD=0.255p PS=2.18u
+ PD=2.18u
M$8 \$1 \$29 \$40 \$1 sg13_lv_nmos L=0.15u W=0.75u AS=0.255p AD=0.1425p
+ PS=2.18u PD=1.13u
M$9 \$40 \$15 \$1 \$1 sg13_lv_nmos L=0.15u W=0.75u AS=0.1425p AD=0.255p
+ PS=1.13u PD=2.18u
M$10 \$40 \$10 \$14 \$1 sg13_lv_nmos L=0.15u W=0.75u AS=0.255p AD=0.255p
+ PS=2.18u PD=2.18u
M$11 \$40 \$10 \$16 \$1 sg13_lv_nmos L=0.15u W=0.75u AS=0.255p AD=0.255p
+ PS=2.18u PD=2.18u
M$12 \$1 \$29 \$7 \$1 sg13_lv_nmos L=0.15u W=0.75u AS=0.255p AD=0.1425p
+ PS=2.18u PD=1.13u
M$13 \$7 \$17 \$1 \$1 sg13_lv_nmos L=0.15u W=0.75u AS=0.1425p AD=0.255p
+ PS=1.13u PD=2.18u
M$14 \$7 \$3 \$16 \$1 sg13_lv_nmos L=0.15u W=0.75u AS=0.255p AD=0.255p PS=2.18u
+ PD=2.18u
M$15 \$66 \$3 \$67 \$1 sg13_lv_nmos L=0.15u W=0.75u AS=0.255p AD=0.255p
+ PS=2.18u PD=2.18u
M$16 \$1 \$2 \$11 \$1 sg13_lv_nmos L=0.15u W=0.75u AS=0.255p AD=0.255p PS=2.18u
+ PD=2.18u
M$17 \$1 \$7 \$12 \$1 sg13_lv_nmos L=0.15u W=0.75u AS=0.255p AD=0.255p PS=2.18u
+ PD=2.18u
M$18 \$68 \$66 \$1 \$1 sg13_lv_nmos L=0.15u W=0.75u AS=0.255p AD=0.255p
+ PS=2.18u PD=2.18u
M$19 \$66 \$63 \$70 \$1 sg13_lv_nmos L=0.15u W=0.75u AS=0.255p AD=0.255p
+ PS=2.18u PD=2.18u
M$20 \$71 \$63 \$70 \$1 sg13_lv_nmos L=0.15u W=0.75u AS=0.255p AD=0.255p
+ PS=2.18u PD=2.18u
M$21 \$1 \$9 \$13 \$1 sg13_lv_nmos L=0.15u W=0.75u AS=0.255p AD=0.255p PS=2.18u
+ PD=2.18u
M$22 \$1 \$3 \$10 \$1 sg13_lv_nmos L=0.15u W=0.75u AS=0.255p AD=0.255p PS=2.18u
+ PD=2.18u
M$23 \$1 \$14 \$15 \$1 sg13_lv_nmos L=0.15u W=0.75u AS=0.255p AD=0.255p
+ PS=2.18u PD=2.18u
M$24 \$72 \$71 \$1 \$1 sg13_lv_nmos L=0.15u W=0.75u AS=0.255p AD=0.255p
+ PS=2.18u PD=2.18u
M$25 \$71 \$3 \$65 \$1 sg13_lv_nmos L=0.15u W=0.75u AS=0.255p AD=0.255p
+ PS=2.18u PD=2.18u
M$26 \$63 \$3 \$1 \$1 sg13_lv_nmos L=0.15u W=0.75u AS=0.255p AD=0.255p PS=2.18u
+ PD=2.18u
M$27 \$73 \$97 \$1 \$1 sg13_lv_nmos L=0.15u W=0.75u AS=0.255p AD=0.255p
+ PS=2.18u PD=2.18u
M$28 \$97 \$67 \$98 \$1 sg13_lv_nmos L=0.15u W=1.5u AS=0.51p AD=0.285p PS=3.68u
+ PD=1.88u
M$29 \$98 \$13 \$1 \$1 sg13_lv_nmos L=0.15u W=1.5u AS=0.285p AD=0.51p PS=1.88u
+ PD=3.68u
M$30 \$1 \$16 \$17 \$1 sg13_lv_nmos L=0.15u W=0.75u AS=0.255p AD=0.255p
+ PS=2.18u PD=2.18u
M$31 \$65 \$67 \$99 \$1 sg13_lv_nmos L=0.15u W=1.5u AS=0.51p AD=0.285p PS=3.68u
+ PD=1.88u
M$32 \$99 \$13 \$1 \$1 sg13_lv_nmos L=0.15u W=1.5u AS=0.285p AD=0.51p PS=1.88u
+ PD=3.68u
M$33 \$65 \$75 \$100 \$1 sg13_lv_nmos L=0.15u W=1.5u AS=0.51p AD=0.285p
+ PS=3.68u PD=1.88u
M$34 \$100 \$64 \$1 \$1 sg13_lv_nmos L=0.15u W=1.5u AS=0.285p AD=0.51p PS=1.88u
+ PD=3.68u
M$35 \$75 \$67 \$1 \$1 sg13_lv_nmos L=0.15u W=0.75u AS=0.255p AD=0.255p
+ PS=2.18u PD=2.18u
M$36 \$64 \$13 \$1 \$1 sg13_lv_nmos L=0.15u W=0.75u AS=0.255p AD=0.255p
+ PS=2.18u PD=2.18u
M$37 \$1 \$68 \$67 \$1 sg13_lv_nmos L=0.15u W=0.75u AS=0.255p AD=0.1425p
+ PS=2.18u PD=1.13u
M$38 \$67 \$29 \$1 \$1 sg13_lv_nmos L=0.15u W=0.75u AS=0.1425p AD=0.255p
+ PS=1.13u PD=2.18u
M$39 \$1 \$129 \$122 \$1 sg13_lv_nmos L=0.15u W=1.5u AS=0.51p AD=0.285p
+ PS=3.68u PD=1.88u
M$40 \$122 \$130 \$123 \$1 sg13_lv_nmos L=0.15u W=1.5u AS=0.285p AD=0.51p
+ PS=1.88u PD=3.68u
M$41 \$1 \$121 \$124 \$1 sg13_lv_nmos L=0.15u W=1.5u AS=0.51p AD=0.285p
+ PS=3.68u PD=1.88u
M$42 \$124 \$125 \$123 \$1 sg13_lv_nmos L=0.15u W=1.5u AS=0.285p AD=0.51p
+ PS=1.88u PD=3.68u
M$43 \$1 \$121 \$126 \$1 sg13_lv_nmos L=0.15u W=1.5u AS=0.51p AD=0.285p
+ PS=3.68u PD=1.88u
M$44 \$126 \$125 \$127 \$1 sg13_lv_nmos L=0.15u W=1.5u AS=0.285p AD=0.51p
+ PS=1.88u PD=3.68u
M$45 \$123 \$3 \$132 \$1 sg13_lv_nmos L=0.15u W=0.75u AS=0.255p AD=0.255p
+ PS=2.18u PD=2.18u
M$46 \$1 \$72 \$70 \$1 sg13_lv_nmos L=0.15u W=0.75u AS=0.255p AD=0.1425p
+ PS=2.18u PD=1.13u
M$47 \$70 \$29 \$1 \$1 sg13_lv_nmos L=0.15u W=0.75u AS=0.1425p AD=0.255p
+ PS=1.13u PD=2.18u
M$48 \$1 \$29 \$158 \$1 sg13_lv_nmos L=0.15u W=0.75u AS=0.255p AD=0.1425p
+ PS=2.18u PD=1.13u
M$49 \$158 \$133 \$1 \$1 sg13_lv_nmos L=0.15u W=0.75u AS=0.1425p AD=0.255p
+ PS=1.13u PD=2.18u
M$50 \$158 \$128 \$132 \$1 sg13_lv_nmos L=0.15u W=0.75u AS=0.255p AD=0.255p
+ PS=2.18u PD=2.18u
M$51 \$158 \$128 \$134 \$1 sg13_lv_nmos L=0.15u W=0.75u AS=0.255p AD=0.255p
+ PS=2.18u PD=2.18u
M$52 \$1 \$29 \$125 \$1 sg13_lv_nmos L=0.15u W=0.75u AS=0.255p AD=0.1425p
+ PS=2.18u PD=1.13u
M$53 \$125 \$135 \$1 \$1 sg13_lv_nmos L=0.15u W=0.75u AS=0.1425p AD=0.255p
+ PS=1.13u PD=2.18u
M$54 \$125 \$3 \$134 \$1 sg13_lv_nmos L=0.15u W=0.75u AS=0.255p AD=0.255p
+ PS=2.18u PD=2.18u
M$55 \$183 \$3 \$184 \$1 sg13_lv_nmos L=0.15u W=0.75u AS=0.255p AD=0.255p
+ PS=2.18u PD=2.18u
M$56 \$1 \$121 \$129 \$1 sg13_lv_nmos L=0.15u W=0.75u AS=0.255p AD=0.255p
+ PS=2.18u PD=2.18u
M$57 \$1 \$125 \$130 \$1 sg13_lv_nmos L=0.15u W=0.75u AS=0.255p AD=0.255p
+ PS=2.18u PD=2.18u
M$58 \$185 \$183 \$1 \$1 sg13_lv_nmos L=0.15u W=0.75u AS=0.255p AD=0.255p
+ PS=2.18u PD=2.18u
M$59 \$183 \$180 \$187 \$1 sg13_lv_nmos L=0.15u W=0.75u AS=0.255p AD=0.255p
+ PS=2.18u PD=2.18u
M$60 \$188 \$180 \$187 \$1 sg13_lv_nmos L=0.15u W=0.75u AS=0.255p AD=0.255p
+ PS=2.18u PD=2.18u
M$61 \$1 \$127 \$131 \$1 sg13_lv_nmos L=0.15u W=0.75u AS=0.255p AD=0.255p
+ PS=2.18u PD=2.18u
M$62 \$1 \$3 \$128 \$1 sg13_lv_nmos L=0.15u W=0.75u AS=0.255p AD=0.255p
+ PS=2.18u PD=2.18u
M$63 \$1 \$132 \$133 \$1 sg13_lv_nmos L=0.15u W=0.75u AS=0.255p AD=0.255p
+ PS=2.18u PD=2.18u
M$64 \$189 \$188 \$1 \$1 sg13_lv_nmos L=0.15u W=0.75u AS=0.255p AD=0.255p
+ PS=2.18u PD=2.18u
M$65 \$188 \$3 \$182 \$1 sg13_lv_nmos L=0.15u W=0.75u AS=0.255p AD=0.255p
+ PS=2.18u PD=2.18u
M$66 \$180 \$3 \$1 \$1 sg13_lv_nmos L=0.15u W=0.75u AS=0.255p AD=0.255p
+ PS=2.18u PD=2.18u
M$67 \$121 \$213 \$1 \$1 sg13_lv_nmos L=0.15u W=0.75u AS=0.255p AD=0.255p
+ PS=2.18u PD=2.18u
M$68 \$213 \$184 \$214 \$1 sg13_lv_nmos L=0.15u W=1.5u AS=0.51p AD=0.285p
+ PS=3.68u PD=1.88u
M$69 \$214 \$73 \$1 \$1 sg13_lv_nmos L=0.15u W=1.5u AS=0.285p AD=0.51p PS=1.88u
+ PD=3.68u
M$70 \$1 \$134 \$135 \$1 sg13_lv_nmos L=0.15u W=0.75u AS=0.255p AD=0.255p
+ PS=2.18u PD=2.18u
M$71 \$182 \$184 \$215 \$1 sg13_lv_nmos L=0.15u W=1.5u AS=0.51p AD=0.285p
+ PS=3.68u PD=1.88u
M$72 \$215 \$73 \$1 \$1 sg13_lv_nmos L=0.15u W=1.5u AS=0.285p AD=0.51p PS=1.88u
+ PD=3.68u
M$73 \$182 \$191 \$216 \$1 sg13_lv_nmos L=0.15u W=1.5u AS=0.51p AD=0.285p
+ PS=3.68u PD=1.88u
M$74 \$216 \$181 \$1 \$1 sg13_lv_nmos L=0.15u W=1.5u AS=0.285p AD=0.51p
+ PS=1.88u PD=3.68u
M$75 \$191 \$184 \$1 \$1 sg13_lv_nmos L=0.15u W=0.75u AS=0.255p AD=0.255p
+ PS=2.18u PD=2.18u
M$76 \$181 \$73 \$1 \$1 sg13_lv_nmos L=0.15u W=0.75u AS=0.255p AD=0.255p
+ PS=2.18u PD=2.18u
M$77 \$1 \$185 \$184 \$1 sg13_lv_nmos L=0.15u W=0.75u AS=0.255p AD=0.1425p
+ PS=2.18u PD=1.13u
M$78 \$184 \$29 \$1 \$1 sg13_lv_nmos L=0.15u W=0.75u AS=0.1425p AD=0.255p
+ PS=1.13u PD=2.18u
M$79 \$1 \$189 \$187 \$1 sg13_lv_nmos L=0.15u W=0.75u AS=0.255p AD=0.1425p
+ PS=2.18u PD=1.13u
M$80 \$187 \$29 \$1 \$1 sg13_lv_nmos L=0.15u W=0.75u AS=0.1425p AD=0.255p
+ PS=1.13u PD=2.18u
M$81 \$2 \$2 \$11 \$2 sg13_lv_pmos L=0.15u W=1.5u AS=0.51p AD=0.51p PS=3.68u
+ PD=3.68u
M$82 \$2 \$7 \$12 \$2 sg13_lv_pmos L=0.15u W=1.5u AS=0.51p AD=0.51p PS=3.68u
+ PD=3.68u
M$83 \$2 \$11 \$28 \$2 sg13_lv_pmos L=0.15u W=1.5u AS=0.51p AD=0.285p PS=3.68u
+ PD=1.88u
M$84 \$28 \$12 \$2 \$2 sg13_lv_pmos L=0.15u W=1.5u AS=0.285p AD=0.51p PS=1.88u
+ PD=3.68u
M$85 \$28 \$2 \$5 \$2 sg13_lv_pmos L=0.15u W=1.5u AS=0.51p AD=0.285p PS=3.68u
+ PD=1.88u
M$86 \$5 \$7 \$28 \$2 sg13_lv_pmos L=0.15u W=1.5u AS=0.285p AD=0.51p PS=1.88u
+ PD=3.68u
M$87 \$2 \$2 \$9 \$2 sg13_lv_pmos L=0.15u W=1.5u AS=0.51p AD=0.285p PS=3.68u
+ PD=1.88u
M$88 \$9 \$7 \$2 \$2 sg13_lv_pmos L=0.15u W=1.5u AS=0.285p AD=0.51p PS=1.88u
+ PD=3.68u
M$89 \$2 \$9 \$13 \$2 sg13_lv_pmos L=0.15u W=1.5u AS=0.51p AD=0.51p PS=3.68u
+ PD=3.68u
M$90 \$2 \$3 \$10 \$2 sg13_lv_pmos L=0.15u W=1.5u AS=0.51p AD=0.51p PS=3.68u
+ PD=3.68u
M$91 \$5 \$10 \$14 \$2 sg13_lv_pmos L=0.15u W=1.5u AS=0.51p AD=0.51p PS=3.68u
+ PD=3.68u
M$92 \$2 \$14 \$15 \$2 sg13_lv_pmos L=0.15u W=1.5u AS=0.51p AD=0.51p PS=3.68u
+ PD=3.68u
M$93 \$40 \$3 \$14 \$2 sg13_lv_pmos L=0.15u W=1.5u AS=0.51p AD=0.51p PS=3.68u
+ PD=3.68u
M$94 \$40 \$3 \$16 \$2 sg13_lv_pmos L=0.15u W=1.5u AS=0.51p AD=0.51p PS=3.68u
+ PD=3.68u
M$95 \$2 \$16 \$17 \$2 sg13_lv_pmos L=0.15u W=1.5u AS=0.51p AD=0.51p PS=3.68u
+ PD=3.68u
M$96 \$7 \$10 \$16 \$2 sg13_lv_pmos L=0.15u W=1.5u AS=0.51p AD=0.51p PS=3.68u
+ PD=3.68u
M$97 \$66 \$63 \$67 \$2 sg13_lv_pmos L=0.15u W=1.5u AS=0.51p AD=0.51p PS=3.68u
+ PD=3.68u
M$98 \$68 \$66 \$2 \$2 sg13_lv_pmos L=0.15u W=1.5u AS=0.51p AD=0.51p PS=3.68u
+ PD=3.68u
M$99 \$66 \$3 \$70 \$2 sg13_lv_pmos L=0.15u W=1.5u AS=0.51p AD=0.51p PS=3.68u
+ PD=3.68u
M$100 \$71 \$3 \$70 \$2 sg13_lv_pmos L=0.15u W=1.5u AS=0.51p AD=0.51p PS=3.68u
+ PD=3.68u
M$101 \$40 \$29 \$41 \$2 sg13_lv_pmos L=0.15u W=3u AS=1.02p AD=0.57p PS=6.68u
+ PD=3.38u
M$102 \$41 \$15 \$2 \$2 sg13_lv_pmos L=0.15u W=3u AS=0.57p AD=1.02p PS=3.38u
+ PD=6.68u
M$103 \$72 \$71 \$2 \$2 sg13_lv_pmos L=0.15u W=1.5u AS=0.51p AD=0.51p PS=3.68u
+ PD=3.68u
M$104 \$71 \$63 \$65 \$2 sg13_lv_pmos L=0.15u W=1.5u AS=0.51p AD=0.51p PS=3.68u
+ PD=3.68u
M$105 \$63 \$3 \$2 \$2 sg13_lv_pmos L=0.15u W=1.5u AS=0.51p AD=0.51p PS=3.68u
+ PD=3.68u
M$106 \$73 \$97 \$2 \$2 sg13_lv_pmos L=0.15u W=1.5u AS=0.51p AD=0.51p PS=3.68u
+ PD=3.68u
M$107 \$2 \$67 \$97 \$2 sg13_lv_pmos L=0.15u W=1.5u AS=0.51p AD=0.285p PS=3.68u
+ PD=1.88u
M$108 \$97 \$13 \$2 \$2 sg13_lv_pmos L=0.15u W=1.5u AS=0.285p AD=0.51p PS=1.88u
+ PD=3.68u
M$109 \$74 \$67 \$65 \$2 sg13_lv_pmos L=0.15u W=1.5u AS=0.51p AD=0.285p
+ PS=3.68u PD=1.88u
M$110 \$65 \$13 \$74 \$2 sg13_lv_pmos L=0.15u W=1.5u AS=0.285p AD=0.51p
+ PS=1.88u PD=3.68u
M$111 \$7 \$29 \$42 \$2 sg13_lv_pmos L=0.15u W=3u AS=1.02p AD=0.57p PS=6.68u
+ PD=3.38u
M$112 \$42 \$17 \$2 \$2 sg13_lv_pmos L=0.15u W=3u AS=0.57p AD=1.02p PS=3.38u
+ PD=6.68u
M$113 \$2 \$75 \$74 \$2 sg13_lv_pmos L=0.15u W=1.5u AS=0.51p AD=0.285p PS=3.68u
+ PD=1.88u
M$114 \$74 \$64 \$2 \$2 sg13_lv_pmos L=0.15u W=1.5u AS=0.285p AD=0.51p PS=1.88u
+ PD=3.68u
M$115 \$75 \$67 \$2 \$2 sg13_lv_pmos L=0.15u W=1.5u AS=0.51p AD=0.51p PS=3.68u
+ PD=3.68u
M$116 \$64 \$13 \$2 \$2 sg13_lv_pmos L=0.15u W=1.5u AS=0.51p AD=0.51p PS=3.68u
+ PD=3.68u
M$117 \$2 \$121 \$129 \$2 sg13_lv_pmos L=0.15u W=1.5u AS=0.51p AD=0.51p
+ PS=3.68u PD=3.68u
M$118 \$2 \$125 \$130 \$2 sg13_lv_pmos L=0.15u W=1.5u AS=0.51p AD=0.51p
+ PS=3.68u PD=3.68u
M$119 \$2 \$68 \$69 \$2 sg13_lv_pmos L=0.15u W=3u AS=1.02p AD=0.57p PS=6.68u
+ PD=3.38u
M$120 \$69 \$29 \$67 \$2 sg13_lv_pmos L=0.15u W=3u AS=0.57p AD=1.02p PS=3.38u
+ PD=6.68u
M$121 \$2 \$129 \$156 \$2 sg13_lv_pmos L=0.15u W=1.5u AS=0.51p AD=0.285p
+ PS=3.68u PD=1.88u
M$122 \$156 \$130 \$2 \$2 sg13_lv_pmos L=0.15u W=1.5u AS=0.285p AD=0.51p
+ PS=1.88u PD=3.68u
M$123 \$156 \$121 \$123 \$2 sg13_lv_pmos L=0.15u W=1.5u AS=0.51p AD=0.285p
+ PS=3.68u PD=1.88u
M$124 \$123 \$125 \$156 \$2 sg13_lv_pmos L=0.15u W=1.5u AS=0.285p AD=0.51p
+ PS=1.88u PD=3.68u
M$125 \$2 \$121 \$127 \$2 sg13_lv_pmos L=0.15u W=1.5u AS=0.51p AD=0.285p
+ PS=3.68u PD=1.88u
M$126 \$127 \$125 \$2 \$2 sg13_lv_pmos L=0.15u W=1.5u AS=0.285p AD=0.51p
+ PS=1.88u PD=3.68u
M$127 \$2 \$127 \$131 \$2 sg13_lv_pmos L=0.15u W=1.5u AS=0.51p AD=0.51p
+ PS=3.68u PD=3.68u
M$128 \$2 \$3 \$128 \$2 sg13_lv_pmos L=0.15u W=1.5u AS=0.51p AD=0.51p PS=3.68u
+ PD=3.68u
M$129 \$2 \$72 \$78 \$2 sg13_lv_pmos L=0.15u W=3u AS=1.02p AD=0.57p PS=6.68u
+ PD=3.38u
M$130 \$78 \$29 \$70 \$2 sg13_lv_pmos L=0.15u W=3u AS=0.57p AD=1.02p PS=3.38u
+ PD=6.68u
M$131 \$123 \$128 \$132 \$2 sg13_lv_pmos L=0.15u W=1.5u AS=0.51p AD=0.51p
+ PS=3.68u PD=3.68u
M$132 \$2 \$132 \$133 \$2 sg13_lv_pmos L=0.15u W=1.5u AS=0.51p AD=0.51p
+ PS=3.68u PD=3.68u
M$133 \$158 \$3 \$132 \$2 sg13_lv_pmos L=0.15u W=1.5u AS=0.51p AD=0.51p
+ PS=3.68u PD=3.68u
M$134 \$158 \$3 \$134 \$2 sg13_lv_pmos L=0.15u W=1.5u AS=0.51p AD=0.51p
+ PS=3.68u PD=3.68u
M$135 \$2 \$134 \$135 \$2 sg13_lv_pmos L=0.15u W=1.5u AS=0.51p AD=0.51p
+ PS=3.68u PD=3.68u
M$136 \$125 \$128 \$134 \$2 sg13_lv_pmos L=0.15u W=1.5u AS=0.51p AD=0.51p
+ PS=3.68u PD=3.68u
M$137 \$183 \$180 \$184 \$2 sg13_lv_pmos L=0.15u W=1.5u AS=0.51p AD=0.51p
+ PS=3.68u PD=3.68u
M$138 \$185 \$183 \$2 \$2 sg13_lv_pmos L=0.15u W=1.5u AS=0.51p AD=0.51p
+ PS=3.68u PD=3.68u
M$139 \$183 \$3 \$187 \$2 sg13_lv_pmos L=0.15u W=1.5u AS=0.51p AD=0.51p
+ PS=3.68u PD=3.68u
M$140 \$188 \$3 \$187 \$2 sg13_lv_pmos L=0.15u W=1.5u AS=0.51p AD=0.51p
+ PS=3.68u PD=3.68u
M$141 \$158 \$29 \$157 \$2 sg13_lv_pmos L=0.15u W=3u AS=1.02p AD=0.57p PS=6.68u
+ PD=3.38u
M$142 \$157 \$133 \$2 \$2 sg13_lv_pmos L=0.15u W=3u AS=0.57p AD=1.02p PS=3.38u
+ PD=6.68u
M$143 \$189 \$188 \$2 \$2 sg13_lv_pmos L=0.15u W=1.5u AS=0.51p AD=0.51p
+ PS=3.68u PD=3.68u
M$144 \$188 \$180 \$182 \$2 sg13_lv_pmos L=0.15u W=1.5u AS=0.51p AD=0.51p
+ PS=3.68u PD=3.68u
M$145 \$180 \$3 \$2 \$2 sg13_lv_pmos L=0.15u W=1.5u AS=0.51p AD=0.51p PS=3.68u
+ PD=3.68u
M$146 \$121 \$213 \$2 \$2 sg13_lv_pmos L=0.15u W=1.5u AS=0.51p AD=0.51p
+ PS=3.68u PD=3.68u
M$147 \$2 \$184 \$213 \$2 sg13_lv_pmos L=0.15u W=1.5u AS=0.51p AD=0.285p
+ PS=3.68u PD=1.88u
M$148 \$213 \$73 \$2 \$2 sg13_lv_pmos L=0.15u W=1.5u AS=0.285p AD=0.51p
+ PS=1.88u PD=3.68u
M$149 \$190 \$184 \$182 \$2 sg13_lv_pmos L=0.15u W=1.5u AS=0.51p AD=0.285p
+ PS=3.68u PD=1.88u
M$150 \$182 \$73 \$190 \$2 sg13_lv_pmos L=0.15u W=1.5u AS=0.285p AD=0.51p
+ PS=1.88u PD=3.68u
M$151 \$125 \$29 \$159 \$2 sg13_lv_pmos L=0.15u W=3u AS=1.02p AD=0.57p PS=6.68u
+ PD=3.38u
M$152 \$159 \$135 \$2 \$2 sg13_lv_pmos L=0.15u W=3u AS=0.57p AD=1.02p PS=3.38u
+ PD=6.68u
M$153 \$2 \$191 \$190 \$2 sg13_lv_pmos L=0.15u W=1.5u AS=0.51p AD=0.285p
+ PS=3.68u PD=1.88u
M$154 \$190 \$181 \$2 \$2 sg13_lv_pmos L=0.15u W=1.5u AS=0.285p AD=0.51p
+ PS=1.88u PD=3.68u
M$155 \$191 \$184 \$2 \$2 sg13_lv_pmos L=0.15u W=1.5u AS=0.51p AD=0.51p
+ PS=3.68u PD=3.68u
M$156 \$181 \$73 \$2 \$2 sg13_lv_pmos L=0.15u W=1.5u AS=0.51p AD=0.51p PS=3.68u
+ PD=3.68u
M$157 \$2 \$185 \$186 \$2 sg13_lv_pmos L=0.15u W=3u AS=1.02p AD=0.57p PS=6.68u
+ PD=3.38u
M$158 \$186 \$29 \$184 \$2 sg13_lv_pmos L=0.15u W=3u AS=0.57p AD=1.02p PS=3.38u
+ PD=6.68u
M$159 \$2 \$189 \$194 \$2 sg13_lv_pmos L=0.15u W=3u AS=1.02p AD=0.57p PS=6.68u
+ PD=3.38u
M$160 \$194 \$29 \$187 \$2 sg13_lv_pmos L=0.15u W=3u AS=0.57p AD=1.02p PS=3.38u
+ PD=6.68u
.ENDS count4bits
