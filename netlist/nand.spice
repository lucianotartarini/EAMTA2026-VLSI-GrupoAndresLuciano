** sch_path: /home/eamtastudent/EAMTA2026-VLSI/design/blocks/nand/schematic/nand.sch
**.subckt nand a b vdd vss out
*.iopin a
*.iopin b
*.iopin vdd
*.iopin vss
*.iopin out
XM1 net2 a vss vss sg13_lv_nmos w=0.15u l=0.13u ng=1
XM2 net2 b net1 vdd sg13_lv_pmos w=0.15u l=0.13u ng=1
XM3 net1 a vdd vdd sg13_lv_pmos w=0.15u l=0.13u ng=1
XM4 net2 b vss vss sg13_lv_nmos w=0.15u l=0.13u ng=1
**.ends
.end
