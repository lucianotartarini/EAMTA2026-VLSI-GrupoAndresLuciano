** sch_path: /home/eamtastudent/EAMTA2026-VLSI/design/blocks/inversor/schematic/inversor.sch
**.subckt inversor
**.ends
.end
