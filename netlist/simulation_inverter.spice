** sch_path: /home/eamtastudent/EAMTA2026-VLSI/verification/testbenches/inverter/simulation_inverter.sch
**.subckt simulation_inverter
x1 avdd1p8 vout vin avss1p8 inverter
x2 avdd1p8 net1 vout avss1p8 inverter
V6 vin avss1p8 PULSE({vdd} 0 0.0 1p 1p {Tclk/4} {Tclk/2}) DC 0 AC 0
V5 avdd1p8 avss1p8 DC{vdd}
V4 avss1p8 GND DC{vss}
C1 net1 avss1p8 1p
**** begin user architecture code

* Circuit Parameters
.param vdd = 1.2
.param vss = 0.0
.param Tclk = 10n
.options TEMP = 27.0
* Include Models - IHP SG13G2
.lib cornerMOSlv.lib mos_tt
* OP Parameters & Singals to save
.save all
*Simulations
.control
tran 0.01u 100n
setplot tran1
plot v(vin) v(vout)+1.2
reset
dc V6 0 1.2 0.01
setplot dc
plot vin vout ylabel vout xlabel vin
set filetype = ascii
write dcsweep.raw
.endc
.end

**** end user architecture code
**.ends

* expanding   symbol:  inverter/schematic/inverter.sym # of pins=4
** sym_path: /home/eamtastudent/EAMTA2026-VLSI/design/inverter/schematic/inverter.sym
** sch_path: /home/eamtastudent/EAMTA2026-VLSI/design/inverter/schematic/inverter.sch
.subckt inverter vdd out in vss
*.iopin vdd
*.iopin vss
*.iopin out
*.iopin in
XM1 out in vss vss sg13_lv_nmos w=0.15u l=0.13u ng=1
XM2 out in vdd vdd sg13_lv_pmos w=0.3u l=0.13u ng=1
.ends

.GLOBAL GND
.end
